addrmap oran_slave {
    name = "O-RAN Slave";
    default sw = rw;
    default hw = r;
    default memwidth = 32;

    reg {
        name = "Version register";

        field {
            sw = r;
            hw = na;
        } val[31:0] = 0x20230411;
    } version @ 0x0;

    reg {
        name = "Tick register";

        field {
            name = "Clear";
        } clear[1:1];

        field {
            name = "Tick";
        } tick[0:0];
    } tick @ 0x20;

    // De-framer

    reg {
        name = "Deframer control register";

        field {
            name = "Enable";
        } en[0:0] = 0x0;

        field {
            name = "udCompHdr is included";
        } has_udcomphdr[8:8] = 0x0;

        field {
            name = "udCompMeth in udCompHdr";
        } udcompmeth[19:16] = 0x0;

        field {
            name = "udIqWidth in udCompHdr";
        } udiqwidth[23:20] = 0x0;
    } defm_ctrl @ 0x100;

    reg {
        name = "Deframer symbol ram read shift";

        field {
            name = "Deframer symbol ram read shift value";
        } val[11:0];
    } defm_syml_rd_shift @ 0x104;

    reg {
        name = "Deframer source MAC address low part";

        field {
            hw = w;
            name = "Deframer source MAC address low part value";
        } val[31:0];
    } defm_src_mac_l @ 0x108;

    reg {
        name = "Deframer source MAC address high part";

        field {
            hw = w;
            name = "Deframer source MAC address high part value";
        } val[15:0];
    } defm_src_mac_h @ 0x10C;

    reg {
        name = "Deframer symbol buffer address offset";

        field {
            name = "Deframer symbol buffer address offset value";
        } val[15:0];
    } defm_buffer_addr_offset[10] @ 0x110;

    reg {
        name = "Total packet counter value";

        field {
            hw = w;
            name = "Low 32-bit value";
        } val[31:0];
    } total_pkt_cnt_lo @ 0x140;

    reg {
        name = "Total packet counter value";

        field {
            hw = w;
            name = "High 16-bit value";
        } val[15:0];
    } total_pkt_cnt_hi @ 0x144;

    reg {
        name = "O-RAN packet counter value";

        field {
            hw = w;
            name = "Low 32-bit value";
        } val[31:0];
    } oran_pkt_cnt_lo @ 0x148;

    reg {
        name = "O-RAN packet counter value";

        field {
            hw = w;
            name = "High 16-bit value";
        } val[15:0];
    } oran_pkt_cnt_hi @ 0x14C;

    reg {
        name = "Ontime packet counter value";

        field {
            hw = w;
            name = "Low 32-bit value";
        } val[31:0];
    } ontime_pkt_cnt_lo @ 0x150;

    reg {
        name = "Ontime packet counter value";

        field {
            hw = w;
            name = "High 16-bit value";
        } val[15:0];
    } ontime_pkt_cnt_hi @ 0x154;

    reg {
        name = "Early packet counter value";

        field {
            hw = w;
            name = "Low 32-bit value";
        } val[31:0];
    } early_pkt_cnt_lo @ 0x158;

    reg {
        name = "Early packet counter value";

        field {
            hw = w;
            name = "High 16-bit value";
        } val[15:0];
    } early_pkt_cnt_hi @ 0x15C;

    reg {
        name = "Late packet counter value";

        field {
            hw = w;
            name = "Low 32-bit value";
        } val[31:0];
    } late_pkt_cnt_lo @ 0x160;

    reg {
        name = "Late packet counter value";

        field {
            hw = w;
            name = "High 16-bit value";
        } val[15:0];
    } late_pkt_cnt_hi @ 0x164;

    reg {
        name = "Earliest packet offset register";

        field {
            hw = w;
            name = "Earliest packet offset value";
        } val[8:0];
    } earliest_u_pkt @ 0x180;

    reg {
        name = "Latest packet offset register";

        field {
            hw = w;
            name = "Latest packet offset value";
        } val[8:0];
    } latest_u_pkt @ 0x184;

    // Framer

    reg {
        name = "Deframer control register";

        field {
            name = "Enable";
        } en[0:0] = 0x0;

        field {
            name = "udCompHdr is included";
        } has_udcomphdr[8:8] = 0x0;

        field {
            name = "udCompMeth in udCompHdr";
        } udcompmeth[19:16] = 0x0;

        field {
            name = "udIqWidth in udCompHdr";
        } udiqwidth[23:20] = 0x0;
    } fram_ctrl @ 0x200;

    reg {
        name = "Framer symbol ram read shift";

        field {
            name = "Framer symbol ram read shift value";
        } val[10:0] = 0x0;
    } fram_syml_rd_shift @ 0x204;

    reg {
        name = "Framer destination MAC address low part";

        field {
            name = "Framer destination MAC address low part value";
        } val[31:0] = 0x22334455;
    } fram_dest_mac_l @ 0x208;

    reg {
        name = "Framer destination MAC address high part";

        field {
            name = "Framer destination MAC address high part value";
        } val[15:0] = 0x0011;
    } fram_dest_mac_h @ 0x20C;

    reg {
        name = "Framer source MAC address low part";

        field {
            name = "Framer source MAC address low part value";
        } val[31:0] = 0x22334466;
    } fram_src_mac_l @ 0x210;

    reg {
        name = "Framer source MAC address high part";

        field {
            name = "Framer source MAC address high part value";
        } val[15:0] = 0x0011;
    } fram_src_mac_h @ 0x214;

    reg {
        name = "Framer VLAN ctrl";

        field {
            name = "Framer has VLAN";
        } has_vlan[16:16] = 0x1;

        field {
            name = "Framer VLAN tag value";
        } vlan_tag[15:0] = 0x7001;
    } fram_vlan_ctrl @ 0x218;

    external mem {
        name = "Framer control buffer 0";

        mementries = 16;
        sw = rw;
    } fram_ctrl_buf0 @ 0x300;

    external mem {
        name = "Symbol mask buffer 0";

        mementries = 32;
        sw = rw;
    } fram_mask_buf0 @ 0x380;

    external mem {
        name = "Framer control buffer 1";

        mementries = 16;
        sw = rw;
    } fram_ctrl_buf1 @ 0x400;

    external mem {
        name = "Framer control buffer 0";

        mementries = 32;
        sw = rw;
    } fram_mask_buf1 @ 0x480;
};

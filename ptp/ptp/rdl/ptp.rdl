addrmap ptp {
    name = "PTP";
    default sw = rw;
    default hw = r;

    reg {
        name = "Control register";

        field {
            name = "Enable";
        } rst [0:0];

        field {
            name = "Enable";
        } enable [8:8];
    } ctrl @ 0x0;

    reg {
        name = "Mode control register";

        field {
            name = "Froce slave mode";
        } slave [0:0];
    } mode @ 0x4;

    // RTC Set

    reg {
        name = "RTC ns offset set register";

        field {
            name = "RTC ns offset set";
        } set [0:0];
    } rtc_offset_set @0x20;

    reg {
        name = "RTC ns offset register";

        field {
            name = "RTC ns offset value";
        } val [31:0];
    } rtc_offset_ns @0x24;

    reg {
        name = "RTC s offset low register";

        field {
            name = "RTC s offset value low bits";
        } val [31:0];
    } rtc_offset_s_l @0x28;

    reg {
        name = "RTC s offset high register";

        field {
            name = "RTC s offset value low bits";
        } val [15:0];
    } rtc_offset_s_h @0x2C;

    // RTC Get

    reg {
        name = "RTC ns offset set register";

        field {
            name = "RTC ns offset set";
        } get [0:0];
    } rtc_offset_get @0x30;

    reg {
        name = "RTC ns offset register";

        field {
            name = "RTC ns offset value";
            hw = w;
        } val [31:0];
    } rtc_ns @0x34;

    reg {
        name = "RTC s offset low register";

        field {
            name = "RTC s offset value low bits";
            hw = w;
        } val [31:0];
    } rtc_s_l @0x38;

    reg {
        name = "RTC s offset high register";

        field {
            name = "RTC s offset value low bits";
            hw = w;
        } val [15:0];
    } rtc_s_h @0x3C;
};

addrmap rts {
    name = "Radio Test Subsystem";
    default sw = rw;
    default hw = r;

    reg {
        name = "Version register";

        field {
            name = "Version value";
            sw = r;
            hw = na;
        } val [31:0] = 32'h20240525;
    } version @ 0x0;

    reg {
        name = "Scratch register 0";

        field {
            name = "Scratch value 0";
            sw = rw;
            hw = na;
        } val [31:0] = 0x0;
    } scratch0 @ 0x4;

    reg {
        name = "Scratch register 1";

        field {
            name = "Scratch value 1";
            sw = rw;
            hw = na;
        } val [31:0] = 0x0;
    } scratch1 @ 0x8;

    reg {
        name = "Source select register";

        field {
            name = "Source select value for CC0";
        } cc0[5:0] = 0x0;

        field {
            name = "Source select value for CC1";
        } cc1[13:8] = 0x0;

        field {
            name = "Source select value for CC1";
        } cc2[21:16] = 0x0;

        field {
            name = "Source select value for CC1";
        } cc3[29:24] = 0x0;
    } src_sel[6] @ 0x14;

    reg {
        name = "RAM readout mode selection register";

        field {
            name = "RAM readout mode selection value";
        } val[2:0] = 0x0;
    } ram_mode @ 0x30;

    reg {
        name = "CW Tone 0 Control";

        field {
            name = "CW Tone 0 Frequency Value";
        } val[19:0] = 0x640;
    } cw0_freq @ 0x40;

    reg {
        name = "CW Tone 0 Control";

        field {
            name = "CW Tone 0 Power Value";
        } val[15:0] = 0x16C3;
    } cw0_pow @ 0x44;

    reg {
        name = "CW Tone 1 Control";

        field {
            name = "CW Tone 1 Frequency Value";
        } val[19:0] = 0xBF9C0;
    } cw1_freq @ 0x48;

    reg {
        name = "CW Tone 1 Control";

        field {
            name = "CW Tone 1 Power Value";
        } val[15:0] = 0x0;
    } cw1_pow @ 0x4C;

    reg {
        name = "RAM address MSB register";

        field {
            name = "RAM address MSB value";
        } val[6:0] = 0x0;
    } injt_ram_addr_msb @ 0x100;

    reg {
        name = "RAM offset register";

        field {
            name = "RAM offset value";
        } val[19:0] = 0x0;
    } ram0_offset @ 0x104;

    reg {
        name = "RAM offset register";

        field {
            name = "RAM offset value";
        } val[19:0] = 0x50000;
    } ram1_offset @ 0x108;

    reg {
        name = "RAM offset register";

        field {
            name = "RAM offset value";
        } val[19:0] = 0xA0000;
    } ram2_offset @ 0x10C;

    reg {
        name = "Capture selection register";

        field {
            name = "Capture position selection value";
        } pos[8:8] = 0x0;

        field {
            name = "Capture channel selection value";
        } cc[5:0] = 0x0;
    } cap_sel @ 0x200;

    reg {
        name = "Capture mode register";

        field {
            name = "Capture mode value";
        } val[1:0] = 0x0;
    } cap_mode @ 0x204;

    reg {
        name = "Capture offset register";

        field {
            name = "Capture offset value";
        } val[18:0] = 0x0;
    } cap_offset @ 0x208;

    reg {
        name = "Capture length register";

        field {
            name = "Capture length value";
        } val[4:0] = 0x1F;
    } cap_len @ 0x20C;

    reg {
        name = "Capture request register";

        field {
            name = "Capture request value";
            sw = rw;
            hw = rw;
        } trigger[0:0] = 0x0;

        field {
            name = "Capture force value";
            sw = rw;
            hw = rw;
        } force[1:1] = 0x0;

        field {
            name = "Capture status value";
            sw = r;
            hw = w;
        } status[4:4];
    } cap_ctrl @ 0x210;

    reg {
        name = "RAM address MSB register";

        field {
            name = "RAM address MSB value";
        } val[3:0] = 0x0;
    } cap_ram_addr_msb @ 0x220;

    external mem {
        name = "RTS Injection RAM";
        mementries = 8192;
        memwidth = 32;
    } injt_ram @ 0x10000;

    external mem {
        name = "RTS Capture RAM";
        mementries = 8192;
        memwidth = 32;
    } cap_ram @ 0x18000;
};
